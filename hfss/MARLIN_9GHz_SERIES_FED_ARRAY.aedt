# Ansys Electronics Desktop project, version 2025.2
materials:
  vacuum: permittivity=1
  Rogers RO4350 (tm): permittivity=3.66 dielectric_loss_tangent=0.004
  copper: permeability=0.999991 conductivity=58000000
  air: permittivity=1.0006 permeability=1.0000004
  pec: conductivity=1e+30
  Teflon (tm): permittivity=2.1 dielectric_loss_tangent=0.001
  gold: permeability=0.99996 conductivity=41000000

design microstrip_ro4350b_60mil (HFSS, HFSS Modal Network, model units mm)
options: Allow_Material_Override Calculate_Lossy_Dielectrics
variables:
  w_dielectric = 50mm
  l_dielectric = 50mm
  h_dielectric = 60mil
  h_copper = 2.6mil
  w_microstrip = 3.342mm
geometry:
  Box1 [Rogers RO4350 (tm)] = box(corner=(-w_dielectric/2, -l_dielectric/2, 0mm), size=(w_dielectric, l_dielectric, h_dielectric))
  Box2 [copper] = box(corner=(-w_dielectric/2, -l_dielectric/2, 0mm), size=(w_dielectric, l_dielectric, -h_copper))
  Box3 [copper] = box(corner=(-w_microstrip/2, -l_dielectric/2, h_dielectric), size=(w_microstrip, l_dielectric, h_copper))
  RadiatingSurface [air] = region(absolute_offset=11.111111mm on all sides)
  Rectangle1 = rectangle(corner=(-5*w_microstrip, -l_dielectric/2, 0mm), z_size=5*h_dielectric, x_size=10*w_microstrip)
  Rectangle2 = rectangle(corner=(-5*w_microstrip, l_dielectric/2, 0mm), z_size=5*h_dielectric, x_size=10*w_microstrip)
  pecCap1 [pec] = sweep_along_normal(Rectangle1.face(at (0, -25, 3.81)), length=-0.1mm)
  pecCap2 [pec] = sweep_along_normal(Rectangle2.face(at (0, 25, 3.81)), length=0.1mm)
boundaries and excitations:
  Open1: Radiation Objects=RadiatingSurface
  1: Wave Port Objects=Rectangle1 WavePortType=Modal NumModes=1 Modes{Mode1{CharImp=Zpi}}
  2: Wave Port Objects=Rectangle2 WavePortType=Modal NumModes=1 Modes{Mode1{CharImp=Zpi}}
setups:
  Setup1: HfssDriven Frequency=9GHz MaxDeltaS=0.01 MaximumPasses=6 MinimumPasses=1 MinimumConvergedPasses=1 PercentRefinement=30 BasisOrder=1 PortAccuracy=2 DrivenSolverType="Direct Solver" SaveRadFieldsOnly
    sweep Sweep: 6GHz to 12GHz, 601 points; Type=Interpolating SaveFields SaveRadFields InterpTolerance=0.5 InterpMaxSolns=250 InterpUsePortImped=false PassivityErrorTolerance=0.0001
source amplitudes:
  1:1: 1W 0deg
  2:1: 0W 0deg
radiation setups:
  3D: Infinite Sphere Theta=0deg..180deg step 2deg Phi=-180deg..180deg step 2deg
  Elevation: Infinite Sphere Theta=-180deg..180deg step 1deg Phi=0deg..90deg step 90deg
  Azimuth: Infinite Sphere Theta=90deg..90deg step 0deg Phi=-180deg..180deg step 1deg
reports:
  S Parameter Plot1: dB(S(1,1)), dB(S(2,1)) vs Freq on Setup1 : Sweep
  Port Zo Plot1: re(Zo(1)), im(Zo(1)) vs Freq on Setup1 : Sweep

design patch_antenna_series_fed_array_ro4350b_60mil (HFSS, HFSS Modal Network, model units mm)
options: Allow_Material_Override Calculate_Lossy_Dielectrics
variables:
  f = 9GHz
  lambda = c0/f
  w_dielectric = 50mm
  l_dielectric = 50mm
  h_dielectric = 60mil
  h_copper = 2.6mil
  w_patch = 11.128mm
  l_patch = 7.37mm
  w_microstrip = 3.342mm
  w_match = 5.75mm
  l_match = 4.75mm
  d_feed = 16.24mm
  w_feed = 0.8mm
geometry:
  Box1 [Rogers RO4350 (tm)] = box(corner=(-w_dielectric/2, -l_dielectric/2, 0mm), size=(w_dielectric, l_dielectric+7*d_feed, h_dielectric))
  Ground [copper] = box(corner=(-w_dielectric/2, -l_dielectric/2, 0mm), size=(w_dielectric, l_dielectric+7*d_feed, -h_copper))
  Patch [copper] = box(corner=(-w_patch/2, -l_patch/2, h_dielectric), size=(w_patch, l_patch, h_copper))
  RadiatingSurface [air] = region(absolute_offset=11.111111mm on all sides)
  Feed [copper] = box(corner=(-w_microstrip/2, -l_dielectric/2, h_dielectric), size=(w_microstrip, l_dielectric/2-l_patch/2-l_match, h_copper))
  Rectangle1 = rectangle(corner=(-5*w_microstrip, -l_dielectric/2, 0mm), z_size=5*h_dielectric, x_size=10*w_microstrip)
  pecCap1 [pec] = sweep_along_normal(Rectangle1.face(at (0, -25, 3.81)), length=-0.1mm)
  Match [copper] = box(corner=(-w_match/2, -l_match-l_patch/2, h_dielectric), size=(w_match, l_match, h_copper))
  Patch.duplicate_along_line(step=(0mm, d_feed, 0mm), total=8, attached)
  SeriesFeed [copper] = box(corner=(-w_feed/2, 0, h_dielectric), size=(w_feed, 7*d_feed, h_copper))
boundaries and excitations:
  Open1: Radiation Objects=RadiatingSurface
  1: Wave Port Objects=Rectangle1 WavePortType=Modal NumModes=1 Modes{Mode1{CharImp=Zpi}}
setups:
  Setup1: HfssDriven Frequency=9GHz MaxDeltaS=0.01 MaximumPasses=6 MinimumPasses=1 MinimumConvergedPasses=1 PercentRefinement=30 BasisOrder=1 PortAccuracy=2 DrivenSolverType="Direct Solver" SaveRadFieldsOnly
    sweep Sweep: 6GHz to 12GHz, 601 points; Type=Interpolating SaveFields SaveRadFields InterpTolerance=0.5 InterpMaxSolns=250 InterpUsePortImped=false PassivityErrorTolerance=0.0001
source amplitudes:
  1:1: 1W 0deg
radiation setups:
  3D: Infinite Sphere Theta=0deg..180deg step 2deg Phi=-180deg..180deg step 2deg
  Elevation: Infinite Sphere Theta=-180deg..180deg step 1deg Phi=0deg..90deg step 90deg
  Azimuth: Infinite Sphere Theta=90deg..90deg step 0deg Phi=-180deg..180deg step 1deg
reports:
  S Parameter Plot1: dB(S(1,1)) vs Freq on Setup1 : Sweep
  Z Parameter Plot1: re(Z(1,1)), im(Z(1,1)) vs Freq on Setup1 : Sweep
  Port Zo Plot1: re(Zo(1)), im(Zo(1)) vs Freq on Setup1 : Sweep
  Realized Gain Plot1: dB(RealizedGainTotal) vs Theta on Setup1 : LastAdaptive, 3D [Phi=-180deg,-90deg Freq=9GHz]
  Realized Gain Plot2: dB(RealizedGainTotal) vs Phi, Theta on Setup1 : LastAdaptive, 3D [Freq=9GHz]

design patch_antenna_series_fed_array_mini_ro4350b_60mil (HFSS, HFSS Modal Network, model units mm)
options: Allow_Material_Override Calculate_Lossy_Dielectrics
variables:
  f = 9GHz
  lambda = c0/f
  w_dielectric = 14mm
  l_dielectric_b = 20mm
  l_dielectric_t = 5mm
  l_dielectric = 12131414mm
  h_dielectric = 60mil
  h_copper = 2.6mil
  w_patch = 11.032mm
  l_patch = 7.61mm
  w_microstrip = 3.342mm
  w_match = 5.65mm
  l_match = 4.71mm
  d_feed = 16.46mm
  w_feed = 0.8mm
geometry:
  Box1 [Rogers RO4350 (tm)] = box(corner=(-w_dielectric/2, -l_dielectric_b, 0mm), size=(w_dielectric, l_dielectric_b+l_dielectric_t+7*d_feed, h_dielectric))
  Ground [copper] = box(corner=(-w_dielectric/2, -l_dielectric_b, 0mm), size=(w_dielectric, l_dielectric_b+l_dielectric_t+7*d_feed, -h_copper))
  Patch [copper] = box(corner=(-w_patch/2, -l_patch/2, h_dielectric), size=(w_patch, l_patch, h_copper))
  RadiatingSurface [air] = region(absolute_offset=11.111111mm on all sides)
  Feed [copper] = box(corner=(-w_microstrip/2, -l_dielectric_b, h_dielectric), size=(w_microstrip, l_dielectric_b-l_patch/2-l_match, h_copper))
  Rectangle1 = rectangle(corner=(-5*w_microstrip, -l_dielectric_b, 0mm), z_size=5*h_dielectric, x_size=10*w_microstrip)
  pecCap1 [pec] = sweep_along_normal(Rectangle1.face(at (0, -20, 3.81)), length=-0.1mm)
  Match [copper] = box(corner=(-w_match/2, -l_match-l_patch/2, h_dielectric), size=(w_match, l_match, h_copper))
  Patch.duplicate_along_line(step=(0mm, d_feed, 0mm), total=8, attached)
  SeriesFeed [copper] = box(corner=(-w_feed/2, 0, h_dielectric), size=(w_feed, 7*d_feed, h_copper))
boundaries and excitations:
  Open1: Radiation Objects=RadiatingSurface
  1: Wave Port Objects=Rectangle1 WavePortType=Modal NumModes=1 Modes{Mode1{CharImp=Zpi}}
setups:
  Setup1: HfssDriven Frequency=9GHz MaxDeltaS=0.01 MaximumPasses=6 MinimumPasses=1 MinimumConvergedPasses=1 PercentRefinement=30 BasisOrder=1 PortAccuracy=2 DrivenSolverType="Direct Solver" SaveRadFieldsOnly
    sweep Sweep: 6GHz to 12GHz, 601 points; Type=Interpolating SaveFields SaveRadFields InterpTolerance=0.5 InterpMaxSolns=250 InterpUsePortImped=false PassivityErrorTolerance=0.0001
source amplitudes:
  1:1: 1W 0deg
radiation setups:
  3D: Infinite Sphere Theta=0deg..180deg step 2deg Phi=-180deg..180deg step 2deg
  Elevation: Infinite Sphere Theta=-180deg..180deg step 1deg Phi=0deg..90deg step 90deg
  Azimuth: Infinite Sphere Theta=90deg..90deg step 0deg Phi=-180deg..180deg step 1deg
reports:
  S Parameter Plot1: dB(S(1,1)) vs Freq on Setup1 : Sweep
  Z Parameter Plot1: re(Z(1,1)), im(Z(1,1)) vs Freq on Setup1 : Sweep
  Port Zo Plot1: re(Zo(1)), im(Zo(1)) vs Freq on Setup1 : Sweep
  Realized Gain Plot1: dB(RealizedGainTotal) vs Theta on Setup1 : LastAdaptive, 3D [Phi=-180deg,-90deg Freq=9GHz]
  Realized Gain Plot2: dB(RealizedGainTotal) vs Phi, Theta on Setup1 : LastAdaptive, 3D [Freq=9GHz]

design patch_antenna_series_fed_array_mini_ro4350b_60mil_sma (HFSS, HFSS Modal Network, model units mm)
options: Allow_Material_Override Calculate_Lossy_Dielectrics
variables:
  f = 9GHz
  lambda = c0/f
  w_dielectric = 14mm
  l_dielectric_b = 20mm
  l_dielectric_t = 5mm
  l_dielectric = 12131414mm
  h_dielectric = 60mil
  h_copper = 2.6mil
  w_patch = 11.032mm
  l_patch = 7.61mm
  w_microstrip = 3.342mm
  w_match = 5.65mm
  l_match = 4.71mm
  d_feed = 16.46mm
  w_feed = 0.8mm
geometry:
  Box1 [Rogers RO4350 (tm)] = box(corner=(-w_dielectric/2, -l_dielectric_b, 0mm), size=(w_dielectric, l_dielectric_b+l_dielectric_t+7*d_feed, h_dielectric))
  Ground [copper] = box(corner=(-w_dielectric/2, -l_dielectric_b, 0mm), size=(w_dielectric, l_dielectric_b+l_dielectric_t+7*d_feed, -h_copper))
  Patch [copper] = box(corner=(-w_patch/2, -l_patch/2, h_dielectric), size=(w_patch, l_patch, h_copper))
  RadiatingSurface [air] = region(absolute_offset=11.111111mm on all sides)
  Feed [copper] = box(corner=(-w_microstrip/2, -l_dielectric_b, h_dielectric), size=(w_microstrip, l_dielectric_b-l_patch/2-l_match, h_copper))
  Match [copper] = box(corner=(-w_match/2, -l_match-l_patch/2, h_dielectric), size=(w_match, l_match, h_copper))
  Patch.duplicate_along_line(step=(0mm, d_feed, 0mm), total=8, attached)
  SeriesFeed [copper] = box(corner=(-w_feed/2, 0, h_dielectric), size=(w_feed, 7*d_feed, h_copper))
  Body3 [Teflon (tm)] = imported_body(C:\Users\tryua\Documents\Ansoft\Connector_STEP.step)
  Body3.rotate(axis=Y, angle=180deg)
  Body3.rotate(axis=Y, angle=180deg)
  Body3.move(3.2e-05mm, -20mm, 1.59004mm)
  Body2 [gold] = imported_body(C:\Users\tryua\Documents\Ansoft\Connector_STEP.step)
  Body2.rotate(axis=Y, angle=180deg)
  Body2.rotate(axis=Y, angle=180deg)
  Body2.move(3.2e-05mm, -20mm, 1.59004mm)
  Body1 [copper] = imported_body(C:\Users\tryua\Documents\Ansoft\Connector_STEP.step)
  Body1.rotate(axis=Y, angle=180deg)
  Body1.rotate(axis=Y, angle=180deg)
  Body1.move(3.2e-05mm, -20mm, 1.59004mm)
  Body4 = imported_body(C:\Users\tryua\Documents\Ansoft\Connector_STEP.step)
  Body4.rotate(axis=Y, angle=180deg)
  Body4_ObjectFromFace1 [Teflon (tm)] = object_from(?.face(at (3.2e-05, -2.14159, -0.0867)))
  Body4.delete()
  pecCap1 [pec] = object_from(Body4_ObjectFromFace1.edge(at (0, -22.1416, 1.25854)))
  Body4_ObjectFromFace1.rotate(axis=Y, angle=180deg)
  Body4_ObjectFromFace1.move(3.2e-05mm, -20mm, 1.59004mm)
  pecCap1.thicken(0.1mm)
  pecCap1.rotate(axis=Y, angle=180deg)
  pecCap1.move(3.2e-05mm, -20mm, 1.59004mm)
  group Connector_STEP = Body3, Body2, Body1, Body4_ObjectFromFace1, pecCap1
boundaries and excitations:
  Open1: Radiation Objects=RadiatingSurface
  2: Wave Port Objects=Body4_ObjectFromFace1 WavePortType=Modal NumModes=1 Modes{Mode1{IntLine{(0, -22.141592, 1.25854) -> (0, -22.141592, 1.54924)} CharImp=Zpi}}
setups:
  Setup1: HfssDriven Frequency=9GHz MaxDeltaS=0.01 MaximumPasses=6 MinimumPasses=1 MinimumConvergedPasses=1 PercentRefinement=30 BasisOrder=1 PortAccuracy=2 DrivenSolverType="Direct Solver" SaveRadFieldsOnly
    sweep Sweep: 6GHz to 12GHz, 601 points; Type=Interpolating SaveFields SaveRadFields InterpTolerance=0.5 InterpMaxSolns=250 InterpUsePortImped=false PassivityErrorTolerance=0.0001
source amplitudes:
  2:1: 1 0deg
radiation setups:
  3D: Infinite Sphere Theta=0deg..180deg step 2deg Phi=-180deg..180deg step 2deg
  Elevation: Infinite Sphere Theta=-180deg..180deg step 1deg Phi=0deg..90deg step 90deg
  Azimuth: Infinite Sphere Theta=90deg..90deg step 0deg Phi=-180deg..180deg step 1deg
reports:
  S Parameter Plot1: dB(S(1,1)) vs Freq on Setup1 : Sweep
  Z Parameter Plot1: re(Z(1,1)), im(Z(1,1)) vs Freq on Setup1 : Sweep
  Port Zo Plot1: re(Zo(1)), im(Zo(1)) vs Freq on Setup1 : Sweep
  Realized Gain Plot1: dB(RealizedGainTotal) vs Theta on Setup1 : LastAdaptive, 3D [Phi=-180deg,-90deg Freq=9GHz]
  Realized Gain Plot2: dB(RealizedGainTotal) vs Phi, Theta on Setup1 : LastAdaptive, 3D [Freq=9GHz]
